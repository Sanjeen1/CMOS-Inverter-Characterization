* SPICE3 file created from inv.ext - technology: tsmc

.include ./tsmc180.txt
.option scale=0.06u

Vdd vdd Gnd 1.8
Vdin in Gnd pulse(0 1.8 1p 10p 10p 10n 20n)

M1000 out in Gnd Gnd nfet w=9 l=3
+  ad=143 pd=50 as=90 ps=38
M1001 out in vdd vdd pfet w=8 l=3
+  ad=128 pd=48 as=80 ps=36

.control
run
setplot tran
plot out  in+8
.endc

.tran 10n 100n
.end
